simulator lang=spectre
global 0
include "/opt/pdk/tsmc28hpcp_1p8m_5x2z/models/spectre/cln28hpcp_1d8_elk_v1d0_2p2_shrink0d9_embedded_usage.scs" section=sfmacro_mos_moscap

VDD (VDDA VDDS) vsource dc=1.0
VSS (VDDS 0) vsource dc=0
VIP_SRC (VIP VDDS) vsource dc=450m mag=0.5 phase=0 type=dc
VIN_SRC (VIN VDDS) vsource dc=450m mag=0.5 phase=180 type=dc

// FC_OTA_0P9V_TSMC28/fold_cascode_2stage_1v_mirrorbias_tt/schematic
IREF2 (VBIAS2 VDDS) isource dc=250u type=dc
I0 (net032 VDDS) isource dc=122.408u type=dc
MP2REF (VBIAS2 VBIAS2 VDDA VDDA) pch_mac l=120.0n w=4u multi=1 nf=2
MP2N (OUTN VBP2 VDDA VDDA) pch_mac l=120.0n w=40u multi=1 nf=20
MP2P (OUTP VBP2 VDDA VDDA) pch_mac l=120.0n w=40u multi=1 nf=20
M37 (net9 VFB VDDA VDDA) pch_mac l=120.0n w=40u multi=1 nf=20
M35 (net8 VFB VDDA VDDA) pch_mac l=120.0n w=40u multi=1 nf=20
M34 (VB1 net063 net048 VDDA) pch_mac l=240.0n w=24.0u multi=2 nf=24
M33 (net048 net064 VDDA VDDA) pch_mac l=120.0n w=40u multi=2 nf=20
M30 (VB3 VB3 net050 VDDA) pch_mac l=240.0n w=24.0u multi=1 nf=24
M29 (net050 VB3 VDDA VDDA) pch_mac l=240.0n w=3.6u multi=1 nf=6
M26 (VB2 VB3 net052 VDDA) pch_mac l=240.0n w=24.0u multi=2 nf=24
M25 (net052 VB2 VDDA VDDA) pch_mac l=120.0n w=40u multi=1 nf=20
M22 (net015 net063 net053 VDDA) pch_mac l=240.0n w=24.0u multi=2 nf=24
M21 (net053 net064 VDDA VDDA) pch_mac l=120.0n w=40u multi=2 nf=20
M18 (VB4 net063 net030 VDDA) pch_mac l=240.0n w=24.0u multi=2 nf=24
M17 (net030 net064 VDDA VDDA) pch_mac l=120.0n w=40u multi=2 nf=20
M14 (net032 net063 net064 VDDA) pch_mac l=240.0n w=24.0u multi=1 nf=24
M13 (net064 net064 VDDA VDDA) pch_mac l=120.0n w=40u multi=1 nf=20
M12 (VB5 net063 net034 VDDA) pch_mac l=240.0n w=24.0u multi=2 nf=24
M11 (net034 net064 VDDA VDDA) pch_mac l=120.0n w=40u multi=2 nf=20
M6 (VON VB3 net8 VDDA) pch_mac l=180.0n w=18.0u multi=1 nf=18
M5 (VOP VB3 net9 VDDA) pch_mac l=180.0n w=18.0u multi=1 nf=18
M1 (net8 VB2 VDDA VDDA) pch_mac l=120.0n w=40u multi=1 nf=20
M0 (net9 VB2 VDDA VDDA) pch_mac l=120.0n w=40u multi=1 nf=20
MN2N (OUTN VON VDDS VDDS) nch_lvt_mac l=60n w=40u multi=1 nf=40
MN2P (OUTP VOP VDDS VDDS) nch_lvt_mac l=60n w=40u multi=1 nf=40
M36 (VB1 VB1 VDDS VDDS) nch_lvt_mac l=90n w=18.0u multi=1 nf=24
M32 (net049 net014 VDDS VDDS) nch_lvt_mac l=180.0n w=24.0u multi=1 nf=16
M31 (VB3 net015 net049 VDDS) nch_lvt_mac l=180.0n w=24.0u multi=1 nf=16
M28 (net051 net014 VDDS VDDS) nch_lvt_mac l=180.0n w=24.0u multi=2 nf=16
M27 (VB2 net015 net051 VDDS) nch_lvt_mac l=180.0n w=24.0u multi=2 nf=16
M24 (net014 net014 VDDS VDDS) nch_lvt_mac l=180.0n w=24.0u multi=1 nf=16
M23 (net015 net015 net014 VDDS) nch_lvt_mac l=180.0n w=24.0u multi=1 nf=16
M20 (net031 VB4 VDDS VDDS) nch_lvt_mac l=180.0n w=3.2u multi=1 nf=4
M19 (VB4 VB4 net031 VDDS) nch_lvt_mac l=180.0n w=24.0u multi=1 nf=16
M16 (net033 VB5 VDDS VDDS) nch_lvt_mac l=180.0n w=24.0u multi=1 nf=16
M15 (VB5 VB4 net033 VDDS) nch_lvt_mac l=180.0n w=24.0u multi=1 nf=16
M10 (net15 VB5 VDDS VDDS) nch_lvt_mac l=180.0n w=27.44u multi=1 nf=16
M9 (net14 VB5 VDDS VDDS) nch_lvt_mac l=180.0n w=27.44u multi=1 nf=16
M8 (VOP VB4 net14 VDDS) nch_lvt_mac l=180.0n w=24.0u multi=1 nf=16
M7 (VON VB4 net15 VDDS) nch_lvt_mac l=180.0n w=24.0u multi=1 nf=16
M4 (net1 VB1 VDDS VDDS) nch_lvt_mac l=90n w=108.000000u multi=1 nf=144
M3 (net9 VIP net1 VDDS) nch_lvt_mac l=60n w=27.0u multi=1 nf=18
M2 (net8 VIN net1 VDDS) nch_lvt_mac l=60n w=27.0u multi=1 nf=18
ECM2 (VBP2 VBIAS2 VCM2 VCMREF2) vcvs gain=100
E0 (VFB VB2 net055 net056) vcvs gain=50 min=-0.9 max=0.9
VREF2 (VCMREF2 VDDS) vsource dc=450m type=dc
V1 (net056 VDDS) vsource dc=450.00m type=dc
VCM2S (VCM2 VDDS) bsource v=0.5*(V(OUTP)+V(OUTN))
V0 (net055 VDDS) bsource v=0.5*(V(VOP)+V(VON))
RZN (OUTN NZN) resistor r=300
RZP (OUTP NZP) resistor r=300
CLOADN (OUTN VDDS) capacitor c=50f
CLOADP (OUTP VDDS) capacitor c=50f
CCN2 (NZN VON) capacitor c=122f
CCP2 (NZP VOP) capacitor c=122f

dcOp dc maxiters=200
ac ac start=1k stop=100G dec=100
save OUTP OUTN VOP VON VBIAS2 VBP2 VCM2 VDDA VDDS VDD:p
saveOptions options save=selected
